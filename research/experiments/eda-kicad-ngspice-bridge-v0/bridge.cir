* Ordivon bounded KiCad -> ngspice bridge v0
* KiCad selected lines: R3=100k, C2=680n
* Explicit mapping: Net-_P2-P1_->OUT, Net-_U1A-K_->IN, GND->0
VTEST IN 0 AC 1
R3 OUT 0 100k
C2 OUT IN 680n
.ac lin 1 2.34051386899846 2.34051386899846
.print ac vr(OUT) vi(OUT)
.end
