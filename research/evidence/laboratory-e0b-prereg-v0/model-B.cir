* E0-B prereg synthetic model B
V1 in 0 PULSE(0 3.0 0 1n 1n 30m 60m)
R1 in out 4.7k
C1 out 0 1u
.tran 1u 0.0235
.meas tran t63 WHEN v(out)=1.89636167649 RISE=1
.meas tran v_tau FIND v(out) AT=0.0047
.end
