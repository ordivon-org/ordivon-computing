* E0-B prereg v0.2 synthetic model A; Pico 2 nominal 3.3 V GPIO step
V1 in 0 PULSE(0 3.3 0 1n 1n 30m 60m)
R1 in out 1k
C1 out 0 1u
.tran 1u 0.015
.meas tran t63 WHEN v(out)=2.08599784413 RISE=1
.meas tran v_tau FIND v(out) AT=0.001
.end
